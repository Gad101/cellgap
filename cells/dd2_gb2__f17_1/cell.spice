* Generated reference circuit; dimensions in micrometers.
.subckt dd2_gb2__f17_1 A B C VGND VNB VPB VPWR Y
XM0 Y A _net1 VNB sky130_fd_pr__nfet_01v8 w=0.420 l=0.150
XM1 _net1 B VGND VNB sky130_fd_pr__nfet_01v8 w=0.420 l=0.150
XM2 Y C _net2 VNB sky130_fd_pr__nfet_01v8 w=0.420 l=0.150
XM3 _net2 A VGND VNB sky130_fd_pr__nfet_01v8 w=0.420 l=0.150
XM4 _net2 B VGND VNB sky130_fd_pr__nfet_01v8 w=0.420 l=0.150
XM5 Y A _net3 VPB sky130_fd_pr__pfet_01v8_hvt w=1.000 l=0.150
XM6 Y B _net3 VPB sky130_fd_pr__pfet_01v8_hvt w=1.000 l=0.150
XM7 _net3 C VPWR VPB sky130_fd_pr__pfet_01v8_hvt w=1.000 l=0.150
XM8 _net3 A _net4 VPB sky130_fd_pr__pfet_01v8_hvt w=1.000 l=0.150
XM9 _net4 B VPWR VPB sky130_fd_pr__pfet_01v8_hvt w=1.000 l=0.150
.ends dd2_gb2__f17_1
